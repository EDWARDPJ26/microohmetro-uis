* S3 - Offset OPA388 = 5u y FEM termoelectrica en S+ (-10/0/+10 uV), RDUT = 1 mOhm
.PARAM RDUT=1m VSYS=3.5 VOS_OPA=5u VEMF=0
.INC "circuito_v2.inc"
V_OFF OFFCTL 0 PWL(0 1 0.2m 1 0.21m 0)
V_LOW LOWCTL 0 PWL(0 1 12m 1 12.01m 0)
.STEP PARAM VEMF LIST -10u 0 10u
.TRAN 0.25m 24m 0 5u UIC
.PRINT TRAN V([VSET]) V([AIN0],[AIN1]) V([AIN2],[AIN3]) V([AIN1]) V([AIN0]) V([GATE]) V([IPLUS],[IMINUS])
.OPTIONS RELTOL=1e-5 VNTOL=1e-9 ABSTOL=1e-12 NUMDGT=8
.END
