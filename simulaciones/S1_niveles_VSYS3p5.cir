* S1 - Secuencia de 2 niveles (I_L 0-12 ms, I_H 12-24 ms), RDUT=1m..1 ohm, VSYS=3.5 V
.PARAM RDUT=1m VSYS=3.5 VOS_OPA=0 VEMF=0
.INC "circuito_v2.inc"
V_OFF OFFCTL 0 PWL(0 1 0.2m 1 0.21m 0)
V_LOW LOWCTL 0 PWL(0 1 12m 1 12.01m 0)
.STEP PARAM RDUT LIST 1m 10m 100m 1
.TRAN 0.25m 24m 0 5u UIC
.PRINT TRAN V([VSET]) V([AIN0],[AIN1]) V([AIN2],[AIN3]) V([AIN1]) V([AIN0]) V([GATE]) V([IPLUS],[IMINUS])
.OPTIONS RELTOL=1e-5 VNTOL=1e-9 ABSTOL=1e-12 NUMDGT=8
.END
