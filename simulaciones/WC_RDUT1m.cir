* S5 - Worst-Case (sensibilidad + peor caso) de RMED, RDUT=1m, tolerancias del circuito_v2.inc
* Salida: RMED = 0,12 * V(AIN0,AIN1) / V(AIN2,AIN3) en nivel I_H (formula del firmware)
.PARAM RDUT=1m VSYS=3.5 VOS_OPA=0 VEMF=0
.INC "circuito_v2.inc"
V_OFF OFFCTL 0 PWL(0 1 0.2m 1 0.21m 0)
V_LOW LOWCTL 0 0
E_RMED RMED 0 VALUE={IF(TIME>7m,0.12*V(AIN0,AIN1)/(V(AIN2,AIN3)+1e-12),0)}
.TRAN 0.5m 8m 0 10u UIC
.WCASE TRAN V([RMED]) MAX VARY DEV OUTPUT ALL
.OPTIONS RELTOL=1e-5 VNTOL=1e-9 ABSTOL=1e-12 NUMDGT=8
.END
